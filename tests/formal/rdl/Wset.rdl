addrmap test {
    reg reg0 {
        field { sw = rw; hw = r; onwrite = wset; } field0[8] = 0;
    };
    reg0 reg0 @ 0x0;
};
