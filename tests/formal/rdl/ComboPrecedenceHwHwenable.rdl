addrmap top { signal {} en_sig[8]; reg reg0 { field {sw=rw; hw=rw; precedence=hw; hwenable=en_sig;} field0[7:0]=0; } reg0; };
