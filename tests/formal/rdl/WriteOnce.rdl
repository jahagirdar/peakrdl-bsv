addrmap test {
    reg reg0 {
        field { sw = w1; hw = r; } field0[8] = 0;
    };
    reg0 reg0 @ 0x0;
};
