addrmap test {
    reg reg0 {
        field { sw = rw; hw = r; onwrite = woset; } field0[8] = 0;
    };
    reg0 reg0 @ 0x0;
};
