addrmap top {
    signal {} en_sig[8];
    signal {} mask_sig[8];
    reg reg0 {
        field { sw = rw; hw = w; woclr; intr; enable = en_sig; } field0[8] = 0;
        field { sw = rw; hw = w; woclr; intr; mask = mask_sig; } field1[8] = 0;
    };
    reg0 reg0 @ 0x0;
};
