addrmap top {
    signal {} gate_sig[8];
    reg reg0 {
        field {sw=rw; hw=rw; hwmask=gate_sig;} field0[7:0] = 0;
    };
    reg0 reg0 @ 0x0;
};
