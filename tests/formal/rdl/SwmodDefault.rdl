addrmap top {
  reg reg0 {
    field {sw=rw; hw=r; swmod;} field0[7:0]=0;
  } reg0;
};
