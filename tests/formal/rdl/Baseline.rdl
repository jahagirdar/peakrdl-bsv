addrmap top {
    reg reg0 {
        field {sw=rw; hw=r;} field0[7:0] = 0;
    };
    reg0 reg0 @ 0x0;
};
