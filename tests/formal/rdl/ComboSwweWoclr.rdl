addrmap top { signal {} swwe_sig; reg reg0 { field {sw=rw; hw=r; onwrite=woclr; swwe=swwe_sig;} field0[7:0]=0; } reg0; };
