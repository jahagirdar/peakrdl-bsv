addrmap top {
    signal {} gate_sig;
    reg reg0 {
        field {sw=rw; hw=rw; swwel=gate_sig;} field0[7:0] = 0;
    };
    reg0 reg0 @ 0x0;
};
